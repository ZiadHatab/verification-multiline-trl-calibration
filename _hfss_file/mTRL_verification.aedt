# Ansys Electronics Desktop project, version 2021.1
project variables:
  $e_r = 1.73929
  $tand = 0.002
  $er = 3.2
materials:
  Coax_dielectric: permittivity=$e_r delta_H_freq=80000000000
  Megtron7_prepreg_R5680_lossless: permittivity=3.15
  Simple_Absorber: permittivity=1 dielectric_loss_tangent=1
  pec: conductivity=1e+30
  vacuum: permittivity=1
  copper: permeability=0.999991 conductivity=58000000
  Megtron7_prepreg_R5680_lossy_causal: permittivity=3.13518+0.00321182*ln((1.6e+23+Freq*Freq)/(2.74741e+14+Freq*Freq)) conductivity=1e-12+3.57363e-13*Freq*(atan(Freq/1.65753e+07)-atan(Freq/4e+11))
  Megtron7_prepreg_R5680_lossy: permittivity=$er dielectric_loss_tangent=$tand

design impedance_transition (HFSS, DrivenModal, model units mm)
variables:
  sub_length = 0.2mm
  sub_width = 4mm
  sub_thickness = 0.0473mm
  sig_length = 0.1mm
  match_width = 0.094mm
  trace_thickness = 0.0126mm
  step_width = 0.2086mm
  port_height = 20*sub_thickness
geometry:
  SUB [Megtron7_prepreg_R5680_lossy] = polyline((0mm, 0mm, 0mm) (sub_length, 0mm, 0mm), section rectangle width=sub_width height=0mm)
  SUB.thicken(-sub_thickness)
  SIG_match [copper] = polyline((0mm, 0mm, sub_thickness) (sig_length, 0mm, sub_thickness), section rectangle width=match_width height=0mm)
  SIG_match.thicken(-trace_thickness)
  SIG_step [copper] = polyline((sig_length, 0mm, sub_thickness) (sub_length, 0mm, sub_thickness), section rectangle width=step_width height=0mm)
  SIG_step.thicken(-trace_thickness)
  GND [copper] = object_from(SUB.face(at (0.1, 0, 0)))
  GND.thicken(trace_thickness)
  P1 [copper] = object_from(GND.edge(at (0, 0, 0)))
  P2 [copper] = object_from(GND.edge(at (0.2, 0, 0)))
  [P2, P1].sweep_along_vector((0mm, 0mm, port_height))
  [SUB, SIG_match, SIG_step, GND, P1, P2].split(plane=ZX, keep=PositiveOnly)
  Region [vacuum] = region(percentage_offset=0 on all sides)
boundaries and excitations:
  Sym1: Symmetry Faces=Region.face(-y) IsPerfectE=false
  Rad1: Radiation Faces=Region.face(+z, +y)
  1: Wave Port Faces=P1.face(#187) NumModes=1 Modes{Mode1{CharImp=Zpi}}
  2: Wave Port Objects=P2 NumModes=1 Modes{Mode1{CharImp=Zpi}}
setups:
  Setup1: HfssDriven Frequency=110GHz MaxDeltaS=0.001 MaximumPasses=40 MinimumPasses=1 MinimumConvergedPasses=1 PercentRefinement=30 BasisOrder=-1 Target=0.25 PortAccuracy=0.01 UseABCOnPort
    sweep Sweep: 2GHz to 150GHz step 2GHz; Type=Discrete
source amplitudes:
  1:1: 0.5W 0deg
  2:1: 0W 0deg
field plots:
  Mesh1: MeshPlots over P1.face(#187) P2.face(#180) on Setup1 : LastAdaptive at Freq=110GHz Phase=0deg
  Mesh2: MeshPlots in SUB on Setup1 : LastAdaptive at Freq=110GHz Phase=0deg
reports:
  Z0: re(Zo(1)), re(Zo(2)) vs Freq on Setup1 : Sweep; markers m1 at 70GHz, m2 at 116GHz
  ereff: re(-(Gamma(1:1)*c0/2/pi/Freq)^2), re(-(Gamma(2:1)*c0/2/pi/Freq)^2) vs Freq on Setup1 : Sweep
  S Parameter Plot 1: dB(S(1,1)), dB(S(2,1)) vs Freq on Setup1 : Sweep

design __for_image_only (HFSS, DrivenModal, model units mm)
variables:
  sub_length = 0.4mm
  sub_width = 4mm
  sub_thickness = 0.05mm
  sig_length = 0.2mm
  match_width = 0.107mm
  trace_thickness = 0.02mm
  step_width = 0.22mm
  port_height = 10*sub_thickness
geometry:
  SUB [Megtron7_prepreg_R5680_lossy_causal] = polyline((0mm, 0mm, 0mm) (sub_length, 0mm, 0mm), section rectangle width=sub_width height=0mm)
  SUB.thicken(-sub_thickness)
  SIG_match [copper] = polyline((0mm, 0mm, sub_thickness) (sig_length, 0mm, sub_thickness), section rectangle width=match_width height=0mm)
  SIG_match.thicken(-trace_thickness)
  SIG_step [copper] = polyline((sig_length, 0mm, sub_thickness) (sub_length, 0mm, sub_thickness), section rectangle width=step_width height=0mm)
  SIG_step.thicken(-trace_thickness)
  GND [copper] = object_from(SUB.face(at (0.2, 0, 0)))
  GND.thicken(trace_thickness)
  P2, P1 [copper] = object_from(GND.edge(at (0.4, 0, 0), at (0, 0, 0)))
  [P2, P1].sweep_along_vector((0mm, 0mm, port_height))
boundaries and excitations:
  1: Wave Port Objects=P1 NumModes=1 DeembedDist=sig_length Modes{Mode1{CharImp=Zpi}}
  2: Wave Port Objects=P2 NumModes=1 DeembedDist=sig_length Modes{Mode1{CharImp=Zpi}}
setups:
  Setup1: HfssDriven Frequency=110GHz MaxDeltaS=0.0001 MaximumPasses=40 MinimumPasses=1 MinimumConvergedPasses=1 PercentRefinement=30 BasisOrder=-1 Target=0.2 PortAccuracy=0.01 UseABCOnPort
    sweep Sweep: 2GHz to 150GHz step 2GHz; Type=Discrete
source amplitudes:
  1:1: 1W 0deg
  2:1: 0W 0deg
field plots:
  Mesh2: MeshPlots in SUB on Setup1 : LastAdaptive at Freq=110GHz Phase=0deg
reports:
  Z0: re(Zo(1)), re(Zo(2)) vs Freq on Setup1 : Sweep
  ereff: re(-(Gamma(1:1)*c0/2/pi/Freq)^2), re(-(Gamma(2:1)*c0/2/pi/Freq)^2) vs Freq on Setup1 : Sweep
  S Parameter Plot 1: dB(S(1,1)), dB(S(2,1)) vs Freq on Setup1 : Sweep

design impedance_transition_2d_only_ports (HFSS, DrivenModal, model units mm)
variables:
  sub_length = 0.2mm
  sub_width = 5mm
  sub_thickness = 0.0475mm
  sig_length = 0.1mm
  match_width = 0.094mm
  trace_thickness = 0.0134mm
  step_width = 0.2086mm
  port_height = 2mm
  gnd_thickness = 0.015mm
  fillet_rad = 0.004mm
geometry:
  SUB [Megtron7_prepreg_R5680_lossy] = polyline((0mm, 0mm, 0mm) (sub_length, 0mm, 0mm), section rectangle width=sub_width height=0mm)
  SUB.thicken(-sub_thickness)
  SIG_match [copper] = polyline((0mm, 0mm, sub_thickness) (sig_length, 0mm, sub_thickness), section rectangle width=match_width height=0mm)
  SIG_match.thicken(-trace_thickness)
  SIG_step = polyline((sig_length, 0mm, sub_thickness) (sub_length, 0mm, sub_thickness), section rectangle width=step_width height=0mm)
  SIG_step.thicken(-trace_thickness)
  GND [copper] = object_from(SUB.face(at (0.1, 0, 0)))
  GND.thicken(gnd_thickness)
  P1 [copper] = object_from(GND.edge(at (0, 0, 0)))
  P2 [copper] = object_from(GND.edge(at (0.2, 0, 0)))
  [P2, P1].sweep_along_vector((0mm, 0mm, port_height))
  [SUB, SIG_match, SIG_step, GND, P1, P2].split(plane=ZX, keep=PositiveOnly)
  Region [vacuum] = region(percentage_offset=0 on all sides)
  SIG_match.unite(SIG_step)
  SIG_match.fillet(Edges=SIG_match.edge(#109, #110, at (0.05, 0.047, 0.0609)) Radius=fillet_rad Setback=0mm)
boundaries and excitations:
  Sym1: Symmetry Faces=Region.face(-y) IsPerfectE=false
  Rad1: Radiation Faces=Region.face(+z, +y)
  1: Wave Port Faces=P1.face(#187) NumModes=1 Modes{Mode1{IntLine{P1.edge(at (0, 0, 1)) at 0.976 along -> P1.vertex(#241)} CharImp=Zpi}}
  2: Wave Port Objects=P2 NumModes=1 Modes{Mode1{IntLine{P2.edge(at (0.2, 0, 1)) at 0.0237 along -> P2.vertex(#245)} CharImp=Zpi}}
setups:
  Setup1: HfssDriven Frequency=150GHz MaxDeltaS=0.001 MaximumPasses=40 MinimumPasses=1 MinimumConvergedPasses=1 PercentRefinement=30 BasisOrder=-1 PortAccuracy=0.001 UseABCOnPort PortMinTri=100 PortMaxTri=5000 VariablesForDerivatives($er, match_width, step_width, sub_thickness, trace_thickness) VariableFlagsForDerivatives(1, 1, 1, 1, 1)
    sweep Sweep: 2GHz to 150GHz step 2GHz; Type=Discrete
source amplitudes:
  1:1: 0.5W 0deg
  2:1: 0W 0deg
field plots:
  Mesh1: MeshPlots over P1.face(#187) P2.face(#180) on Setup1 : LastAdaptive at Freq=150GHz Phase=0deg
  Mesh2: MeshPlots in SUB on Setup1 : LastAdaptive at Freq=150GHz Phase=0deg
reports:
  ereff: re(-(Gamma(1:1)*c0/2/pi/Freq)^2), re(-(Gamma(2:1)*c0/2/pi/Freq)^2) vs Freq on Setup1 : Sweep
  S Parameter Plot 1: dB(S(1,1)), dB(S(2,1)) vs Freq on Setup1 : Sweep; markers m1 at 12GHz
  re_par_Z0_er: re(partialZo(1,$er)), re(partialZo(2,$er)) vs Freq on Setup1 : Sweep
  im_par_Z0_er: im(partialZo(1,$er)), im(partialZo(2,$er)) vs Freq on Setup1 : Sweep
  re_par_Z0_w: re(partialZo(1,match_width)), re(partialZo(2,step_width)) vs Freq on Setup1 : Sweep
  im_par_Z0_w: im(partialZo(1,match_width)), im(partialZo(2,step_width)) vs Freq on Setup1 : Sweep
  re_par_Z0_t: re(partialZo(1,trace_thickness)), re(partialZo(2,trace_thickness)) vs Freq on Setup1 : Sweep
  im_par_Z0_t: im(partialZo(1,trace_thickness)), im(partialZo(2,trace_thickness)) vs Freq on Setup1 : Sweep
  re_par_Z0_h: re(partialZo(1,sub_thickness)), re(partialZo(2,sub_thickness)) vs Freq on Setup1 : Sweep
  im_par_Z0_h: im(partialZo(1,sub_thickness)), im(partialZo(2,sub_thickness)) vs Freq on Setup1 : Sweep
  im_Z0: im(Zo(1)), im(Zo(2)) vs Freq on Setup1 : Sweep
  re_Z0: re(Zo(1)), re(Zo(2)) vs Freq on Setup1 : Sweep
